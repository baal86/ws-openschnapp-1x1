* NGSPICE file created from ip_amplifier_parax.ext - technology: gf180mcuD

.subckt ip_amplifier_parax vsubs vdd INP INN OUTP
X0 vdd.t8 a_1612_368# OUTP vdd.t10 pfet_03v3 ad=5.28p pd=24.88u as=6.015p ps=13.1u w=12u l=0.5u
X1 a_1424_2016# a_1080_400# a_1080_400# vsubs.t8 nfet_03v3 ad=3.03p pd=7.2u as=3.03p ps=7.2u w=6u l=0.5u
X2 OUTP w_13700_140# cap_pmos_03v3 c_width=13.5u c_length=18u
X3 a_1424_2016# a_1080_400# vsubs.t12 vsubs.t13 nfet_03v3 ad=2.64p pd=12.88u as=3.03p ps=7.2u w=6u l=2u
X4 a_240_2922# a_520_400# vsubs.t15 ppolyf_u_1k r_width=1u r_length=12u
X5 OUTP a_6130_2884# vsubs.t3 vsubs.t2 nfet_03v3 ad=6.03p pd=13.2u as=6.03p ps=13.2u w=12u l=0.5u
X6 a_800_2922# a_1080_400# vsubs.t16 ppolyf_u_1k r_width=1u r_length=12u
X7 OUTP a_6130_2884# vsubs.t3 vsubs.t2 nfet_03v3 ad=6.03p pd=13.2u as=5.28p ps=24.88u w=12u l=0.5u
X8 vsubs.t12 a_1080_400# a_1424_2016# vsubs.t11 nfet_03v3 ad=3.03p pd=7.2u as=3.03p ps=7.2u w=6u l=2u
X9 a_18960_2942# a_18680_420# w_13700_140# ppolyf_u_1k r_width=1u r_length=12u
X10 a_19520_2942# a_19240_420# w_13700_140# ppolyf_u_1k r_width=1u r_length=12u
X11 vsubs.t6 a_6130_2884# OUTP vsubs.t2 nfet_03v3 ad=5.28p pd=24.88u as=6.03p ps=13.2u w=12u l=0.5u
X12 a_18400_2942# a_18120_420# w_13700_140# ppolyf_u_1k r_width=1u r_length=12u
X13 vsubs.t3 a_6130_2884# OUTP vsubs.t2 nfet_03v3 ad=6.03p pd=13.2u as=6.03p ps=13.2u w=12u l=0.5u
X14 a_17840_2942# vdd.t11 w_13700_140# ppolyf_u_1k r_width=1u r_length=12u
X15 a_6130_2884# w_13700_140# cap_pmos_03v3 c_width=13.5u c_length=18u
X16 a_4374_1878# a_1612_368# a_4186_1878# vdd.t1 pfet_03v3 ad=3.03p pd=7.2u as=2.64p ps=12.88u w=6u l=0.5u
X17 a_1612_368# a_1612_368# a_4186_430# vdd.t1 pfet_03v3 ad=3.03p pd=7.2u as=2.64p ps=12.88u w=6u l=0.5u
X18 vsubs.t3 a_6130_536# a_6130_536# vsubs.t18 nfet_03v3 ad=2.64p pd=12.88u as=2.64p ps=12.88u w=6u l=5u
X19 a_1612_368# a_1080_400# a_1424_368# vsubs.t9 nfet_03v3 ad=3.03p pd=7.2u as=3.03p ps=7.2u w=6u l=0.5u
X20 a_4186_430# a_1612_368# a_1612_368# vdd.t4 pfet_03v3 ad=3.03p pd=7.2u as=3.03p ps=7.2u w=6u l=0.5u
X21 a_240_2922# vdd vsubs.t0 ppolyf_u_1k r_width=1u r_length=12u
X22 a_1612_368# a_1080_400# a_1424_368# vsubs.t7 nfet_03v3 ad=3.03p pd=7.2u as=2.64p ps=12.88u w=6u l=0.5u
X23 a_4186_1878# a_1612_368# a_4374_1878# vdd.t4 pfet_03v3 ad=3.03p pd=7.2u as=3.03p ps=7.2u w=6u l=0.5u
X24 a_4186_430# a_1612_368# a_1612_368# vdd.t2 pfet_03v3 ad=3.03p pd=7.2u as=3.03p ps=7.2u w=6u l=0.5u
X25 vsubs.t3 a_6130_536# a_6130_2884# vsubs.t17 nfet_03v3 ad=2.64p pd=12.88u as=2.64p ps=12.88u w=6u l=5u
X26 a_1424_368# a_1080_400# a_1612_368# vsubs.t10 nfet_03v3 ad=3.03p pd=7.2u as=3.03p ps=7.2u w=6u l=0.5u
X27 vdd.t9 a_1612_368# a_4186_430# vdd.t5 pfet_03v3 ad=2.64p pd=12.88u as=3.03p ps=7.2u w=6u l=2u
X28 a_4374_1878# INN a_6130_536# vdd.t0 pfet_03v3 ad=7.92p pd=36.88u as=7.92p ps=36.88u w=18u l=5u
X29 a_18960_2942# a_19240_420# w_13700_140# ppolyf_u_1k r_width=1u r_length=12u
X30 a_1424_368# a_1080_400# a_1612_368# vsubs.t8 nfet_03v3 ad=3.03p pd=7.2u as=3.03p ps=7.2u w=6u l=0.5u
X31 a_4186_1878# a_1612_368# a_4374_1878# vdd.t2 pfet_03v3 ad=3.03p pd=7.2u as=3.03p ps=7.2u w=6u l=0.5u
X32 a_1612_368# a_1612_368# a_4186_430# vdd.t3 pfet_03v3 ad=3.03p pd=7.2u as=3.03p ps=7.2u w=6u l=0.5u
X33 a_18400_2942# a_18680_420# w_13700_140# ppolyf_u_1k r_width=1u r_length=12u
X34 a_1080_400# a_1080_400# a_1424_2016# vsubs.t9 nfet_03v3 ad=3.03p pd=7.2u as=3.03p ps=7.2u w=6u l=0.5u
X35 vsubs.t14 a_1080_400# a_1424_368# vsubs.t11 nfet_03v3 ad=2.64p pd=12.88u as=3.03p ps=7.2u w=6u l=2u
X36 a_17840_2942# a_18120_420# w_13700_140# ppolyf_u_1k r_width=1u r_length=12u
X37 a_800_2922# a_520_400# vsubs.t1 ppolyf_u_1k r_width=1u r_length=12u
X38 a_1080_400# a_1080_400# a_1424_2016# vsubs.t7 nfet_03v3 ad=3.03p pd=7.2u as=2.64p ps=12.88u w=6u l=0.5u
X39 vdd.t6 a_1612_368# a_4186_1878# vdd.t5 pfet_03v3 ad=2.64p pd=12.88u as=3.03p ps=7.2u w=6u l=2u
X40 a_19520_2942# w_13700_140# w_13700_140# ppolyf_u_1k r_width=1u r_length=12u
X41 a_4374_1878# a_1612_368# a_4186_1878# vdd.t3 pfet_03v3 ad=3.03p pd=7.2u as=3.03p ps=7.2u w=6u l=0.5u
X42 a_1424_2016# a_1080_400# a_1080_400# vsubs.t10 nfet_03v3 ad=3.03p pd=7.2u as=3.03p ps=7.2u w=6u l=0.5u
X43 OUTP a_1612_368# vdd.t8 vdd.t7 pfet_03v3 ad=6.015p pd=13.1u as=5.28p ps=24.88u w=12u l=0.5u
X44 a_6130_2884# INP a_4374_1878# vdd.t0 pfet_03v3 ad=8.294p pd=37.56u as=7.92p ps=36.88u w=18u l=5u
R0 vdd.t0 vdd.t7 721.385
R1 vdd.t5 vdd.t11 542.768
R2 vdd.t8 vdd.n0 0.477721
R3 vdd.n0 vdd.t11 1.42911
R4 vdd.n1 vdd.t6 3.51279
R5 vdd.t6 vdd.t0 160.377
R6 vdd.t4 vdd.t5 141.51
R7 vdd.n1 vdd.t1 105.242
R8 vdd.t10 vdd.t8 102.727
R9 vdd.t1 vdd.t2 94.3401
R10 vdd.t2 vdd.t3 94.3401
R11 vdd.t3 vdd.t4 94.3401
R12 vdd.t7 vdd.t10 94.3401
R13 vdd.t9 vdd.n1 3.30996
R14 vdd vdd.t11 2.1185
R15 vdd.t6 vdd.n0 1.21843
R16 vdd.t9 vdd.t11 1.15107
R17 vsubs.n3 vsubs.t3 36.1314
R18 vsubs.n1 vsubs.t3 36.1296
R19 vsubs.n2 vsubs.n1 144219
R20 vsubs.n3 vsubs.n2 144219
R21 vsubs.n3 vsubs.t17 1136.3
R22 vsubs.n1 vsubs.t18 1068.89
R23 vsubs.t18 vsubs.t2 962.963
R24 vsubs.t3 vsubs.n0 5.19935
R25 vsubs.t2 vsubs.t17 852.222
R26 vsubs.t13 vsubs.t11 557.144
R27 vsubs.t11 vsubs.t10 417.858
R28 vsubs.n2 vsubs.t13 360.286
R29 vsubs.t7 vsubs.t16 354.714
R30 vsubs.t8 vsubs.t7 278.572
R31 vsubs.t9 vsubs.t8 278.572
R32 vsubs.t10 vsubs.t9 278.572
R33 vsubs.t0 vsubs 269.44
R34 vsubs.t15 vsubs.t0 260
R35 vsubs.t1 vsubs.t15 260
R36 vsubs.t16 vsubs.t1 260
R37 vsubs.t12 vsubs.n0 0.0127932
R38 vsubs.t3 vsubs.t14 4.9691
R39 vsubs.t14 vsubs 2.65581
R40 vsubs vsubs.n0 2.16786
R41 vsubs.t6 vsubs.t3 1.29525
C0 a_1080_400# a_1424_368# 1.66376f
C1 a_18400_2942# OUTP 0
C2 a_1424_368# vdd 0.34118f
C3 a_1080_400# a_4186_430# 0.00683f
C4 a_17840_2942# OUTP 0.00196f
C5 a_4186_430# a_6130_536# 0.00418f
C6 a_4186_430# vdd 1.93212f
C7 a_18960_2942# a_19520_2942# 0.08879f
C8 a_1080_400# vdd 0.23759f
C9 a_6130_2884# INN 0.00929f
C10 a_1424_2016# a_800_2922# 0.07166f
C11 a_1424_2016# a_1424_368# 0.00526f
C12 vdd a_6130_536# 4.80044f
C13 a_6130_2884# w_13700_140# 11.3936f
C14 w_13700_140# a_19240_420# 0.64626f
C15 a_1424_2016# a_240_2922# 0.0036f
C16 a_4374_1878# OUTP 0.01104f
C17 a_1424_2016# a_1080_400# 4.5475f
C18 a_18400_2942# a_6130_2884# 0.02995f
C19 OUTP INP 0.0931f
C20 a_1424_2016# vdd 0.56148f
C21 a_4186_430# INN 0.01705f
C22 a_6130_2884# a_17840_2942# 0.02977f
C23 a_4374_1878# INP 1.01326f
C24 a_1612_368# OUTP 0.57043f
C25 a_4374_1878# a_1612_368# 1.50907f
C26 w_13700_140# a_18960_2942# 0.52055f
C27 a_1612_368# INP 0.26401f
C28 a_6130_536# INN 1.05475f
C29 vdd INN 2.08589f
C30 a_18680_420# a_19240_420# 0.08879f
C31 w_13700_140# a_6130_536# 0
C32 w_13700_140# vdd 2.90733f
C33 w_13700_140# a_19520_2942# 0.61289f
C34 a_18400_2942# a_18960_2942# 0.08879f
C35 a_4186_1878# a_4374_1878# 2.7956f
C36 a_6130_2884# OUTP 3.37531f
C37 a_6130_2884# a_4374_1878# 0.16555f
C38 a_18120_420# vdd 0.15478f
C39 a_4186_1878# INP 0.02072f
C40 a_4186_1878# a_1612_368# 1.60167f
C41 a_6130_2884# INP 1.05815f
C42 a_6130_2884# a_1612_368# 0.61782f
C43 vdd a_18680_420# 0.05278f
C44 a_18960_2942# OUTP 0
C45 a_4186_430# a_4374_1878# 0.02895f
C46 a_1424_368# a_1612_368# 2.27244f
C47 a_1080_400# a_4374_1878# 0
C48 a_6130_2884# a_4186_1878# 0.0038f
C49 a_4186_430# a_1612_368# 3.56144f
C50 a_6130_536# OUTP 1.80869f
C51 a_4374_1878# a_6130_536# 0.1647f
C52 vdd OUTP 3.35751f
C53 a_4374_1878# vdd 2.37732f
C54 a_18120_420# w_13700_140# 0.55812f
C55 a_1080_400# a_1612_368# 1.34038f
C56 a_6130_536# INP 0.01058f
C57 a_18400_2942# w_13700_140# 0.52055f
C58 vdd INP 1.84875f
C59 a_1612_368# a_6130_536# 0.06012f
C60 w_13700_140# a_17840_2942# 0.6131f
C61 a_1612_368# vdd 7.07798f
C62 a_4186_1878# a_4186_430# 0.02111f
C63 a_18400_2942# a_17840_2942# 0.08879f
C64 a_6130_2884# a_18960_2942# 0.03052f
C65 w_13700_140# a_18680_420# 0.55701f
C66 a_1080_400# a_4186_1878# 0
C67 a_1424_2016# a_1612_368# 0.71887f
C68 OUTP INN 0.0937f
C69 a_4374_1878# INN 0.8975f
C70 a_4186_1878# vdd 1.56751f
C71 a_6130_2884# a_6130_536# 0.62008f
C72 a_18120_420# a_18680_420# 0.08879f
C73 a_6130_2884# vdd 5.3287f
C74 a_240_2922# a_800_2922# 0.06564f
C75 a_6130_2884# a_19520_2942# 0.03415f
C76 vdd a_19240_420# 0.05143f
C77 w_13700_140# OUTP 11.0927f
C78 INP INN 0.09031f
C79 a_1080_400# a_520_400# 0.07233f
C80 a_4186_430# a_1424_368# 0.00137f
C81 a_1612_368# INN 0.02481f
C82 a_520_400# vdd 0.0937f
C83 a_1080_400# a_800_2922# 0.00522f
C84 OUTP vsubs 3.98665f
C85 vdd vsubs 92.7029f
C86 a_19520_2942# vsubs 0.09593f
C87 a_19240_420# vsubs 0.09564f
C88 a_18960_2942# vsubs 0.09495f
C89 a_18680_420# vsubs 0.09564f
C90 a_18400_2942# vsubs 0.09495f
C91 a_18120_420# vsubs 0.09564f
C92 a_17840_2942# vsubs 0.09593f
C93 a_6130_536# vsubs 0.06906f
C94 a_4186_430# vsubs 0.05612f
C95 a_6130_2884# vsubs 0.07012f
C96 a_4186_1878# vsubs 0.01223f
C97 a_4374_1878# vsubs 0.17566f
C98 a_1424_368# vsubs 1.55522f
C99 a_800_2922# vsubs 0.82448f
C100 a_520_400# vsubs 0.81216f
C101 a_240_2922# vsubs 0.90259f
C102 a_1424_2016# vsubs 5.19732f
C103 w_13700_140# vsubs 0.12584p
C104 vsubs.t3 vsubs 5.64047f
C105 vdd.t6 vsubs 2.36912f
C106 vdd.t9 vsubs 0.58016f
C107 vdd.t8 vsubs 4.73076f
C108 vdd.t11 vsubs 9.36058f
C109 vdd.n1 vsubs 1.46868f
C110 vdd.t10 vsubs 0.95576f
C111 vdd.t7 vsubs 3.95235f
C112 vdd.t0 vsubs 4.27232f
C113 vdd.t5 vsubs 3.31546f
C114 vdd.t4 vsubs 1.14274f
C115 vdd.t3 vsubs 0.91419f
C116 vdd.t2 vsubs 0.91419f
C117 vdd.t1 vsubs 0.96756f
.ends
