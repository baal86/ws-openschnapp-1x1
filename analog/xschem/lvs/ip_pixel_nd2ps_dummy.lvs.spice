** sch_path: /home/nixos/projects/ws-openschnapp-1x1/analog/xschem/ip_pixel_nd2ps_dummy.sch
.subckt ip_pixel_nd2ps_dummy vdd reset read vsubs cl
*.PININFO vdd:B vsubs:B reset:I read:I cl:O
D2 vsubs siminj diode_nd2ps_06v0 area=0.16125n pj='2*13.5u + 2*13.5u ' m=1
XM4 vdd siminj sfout vsubs nfet_06v0 L=1.9u W=3.5u nf=1 ad='int((nf+1)/2) * W/nf * 0.18u' as='int((nf+2)/2) * W/nf * 0.18u' pd='2*int((nf+1)/2) * (W/nf + 0.18u)'
+ ps='2*int((nf+2)/2) * (W/nf + 0.18u)' nrd='0.18u / W' nrs='0.18u / W' sa=0 sb=0 sd=0 m=1 par=1
XM2 vdd reset siminj vsubs nfet_06v0 L=1.3u W=0.30u nf=1 ad='int((nf+1)/2) * W/nf * 0.18u' as='int((nf+2)/2) * W/nf * 0.18u' pd='2*int((nf+1)/2) * (W/nf + 0.18u)'
+ ps='2*int((nf+2)/2) * (W/nf + 0.18u)' nrd='0.18u / W' nrs='0.18u / W' sa=0 sb=0 sd=0 m=1 par=1
XM1 sfout read cl vsubs nfet_06v0 L=0.7u W=0.30u nf=1 ad='int((nf+1)/2) * W/nf * 0.18u' as='int((nf+2)/2) * W/nf * 0.18u' pd='2*int((nf+1)/2) * (W/nf + 0.18u)'
+ ps='2*int((nf+2)/2) * (W/nf + 0.18u)' nrd='0.18u / W' nrs='0.18u / W' sa=0 sb=0 sd=0 m=1 par=1
.ends
