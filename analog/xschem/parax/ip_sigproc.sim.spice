* NGSPICE file created from ip_sigproc_parax.ext - technology: gf180mcuD

.subckt ip_sigproc_parax VSUBS OUTP VDD SIG REF
X0 a_24600_2200# a_27722_1920# VSUBS.t21 ppolyf_u_1k r_width=1u r_length=15u
X1 X1.vdd.t7 a_1612_368# s1_out X1.vdd.t9 pfet_03v3 ad=5.28p pd=24.88u as=6.015p ps=13.1u w=12u l=0.5u
X2 a_24600_520# s2_fb VSUBS.t0 ppolyf_u_1k r_width=1u r_length=15u
X3 s1_out a_6130_2884# cap_mim_2f0_m4m5_noshield c_width=10u c_length=10u
X4 a_1424_2016# a_1080_400# a_1080_400# VSUBS.t14 nfet_03v3 ad=3.03p pd=7.2u as=3.03p ps=7.2u w=6u l=0.5u
X5 a_32386_1878# a_29812_368# a_32574_1878# VDD.t4 pfet_03v3 ad=3.03p pd=7.2u as=3.03p ps=7.2u w=6u l=0.5u
X6 a_1424_2016# a_1080_400# VSUBS.t18 VSUBS.t19 nfet_03v3 ad=2.64p pd=12.88u as=3.03p ps=7.2u w=6u l=2u
X7 a_29000_2922# a_29280_400# VSUBS.t23 ppolyf_u_1k r_width=1u r_length=12u
X8 a_240_2922# a_520_400# VSUBS.t6 ppolyf_u_1k r_width=1u r_length=12u
X9 s1_out a_6130_2884# VSUBS.t4 VSUBS.t8 nfet_03v3 ad=6.03p pd=13.2u as=6.03p ps=13.2u w=12u l=0.5u
X10 a_800_2922# a_1080_400# VSUBS.t27 ppolyf_u_1k r_width=1u r_length=12u
X11 s1_out a_6130_2884# VSUBS.t4 VSUBS.t8 nfet_03v3 ad=6.03p pd=13.2u as=5.28p ps=24.88u w=12u l=0.5u
X12 a_32386_1878# a_29812_368# a_32574_1878# VDD.t2 pfet_03v3 ad=3.03p pd=7.2u as=3.03p ps=7.2u w=6u l=0.5u
X13 VSUBS.t18 a_1080_400# a_1424_2016# VSUBS.t17 nfet_03v3 ad=3.03p pd=7.2u as=3.03p ps=7.2u w=6u l=2u
X14 a_24600_1080# a_27722_800# VSUBS.t2 ppolyf_u_1k r_width=1u r_length=15u
X15 a_29280_400# a_29280_400# a_29624_2016# VSUBS.t33 nfet_03v3 ad=3.03p pd=7.2u as=3.03p ps=7.2u w=6u l=0.5u
X16 s2_out a_29812_368# VDD.t9 VDD.t8 pfet_03v3 ad=6.015p pd=13.1u as=5.28p ps=24.88u w=12u l=0.5u
X17 VSUBS.t4 a_6130_2884# s1_out VSUBS.t8 nfet_03v3 ad=5.28p pd=24.88u as=6.03p ps=13.2u w=12u l=0.5u
X18 VSUBS.t4 a_6130_2884# s1_out VSUBS.t8 nfet_03v3 ad=6.03p pd=13.2u as=6.03p ps=13.2u w=12u l=0.5u
X19 a_24600_1640# a_27722_1920# VSUBS.t1 ppolyf_u_1k r_width=1u r_length=15u
X20 VSUBS.t29 a_34330_536# a_34330_2884# VSUBS.t30 nfet_03v3 ad=2.64p pd=12.88u as=2.64p ps=12.88u w=6u l=5u
X21 VDD.t9 a_29812_368# s2_out VDD.t10 pfet_03v3 ad=5.28p pd=24.88u as=6.015p ps=13.1u w=12u l=0.5u
X22 s1_out s2_fb VSUBS.t32 ppolyf_u_1k r_width=1u r_length=15u
X23 VDD.t6 a_29812_368# a_32386_1878# VDD.t5 pfet_03v3 ad=2.64p pd=12.88u as=3.03p ps=7.2u w=6u l=2u
X24 a_4374_1878# a_1612_368# a_4186_1878# X1.vdd.t0 pfet_03v3 ad=3.03p pd=7.2u as=2.64p ps=12.88u w=6u l=0.5u
X25 a_24600_2760# s2_out VSUBS.t24 ppolyf_u_1k r_width=1u r_length=15u
X26 a_28440_2922# a_28720_400# VSUBS.t23 ppolyf_u_1k r_width=1u r_length=12u
X27 s2_out a_34330_2884# cap_mim_2f0_m4m5_noshield c_width=10u c_length=10u
X28 a_29812_368# a_29280_400# a_29624_368# VSUBS.t3 nfet_03v3 ad=3.03p pd=7.2u as=2.64p ps=12.88u w=6u l=0.5u
X29 a_1612_368# a_1612_368# a_4186_430# X1.vdd.t0 pfet_03v3 ad=3.03p pd=7.2u as=2.64p ps=12.88u w=6u l=0.5u
X30 VSUBS.t4 a_6130_536# a_6130_536# VSUBS.t3 nfet_03v3 ad=2.64p pd=12.88u as=2.64p ps=12.88u w=6u l=5u
X31 a_29280_400# a_29280_400# a_29624_2016# VSUBS.t33 nfet_03v3 ad=3.03p pd=7.2u as=2.64p ps=12.88u w=6u l=0.5u
X32 a_1612_368# a_1080_400# a_1424_368# VSUBS.t15 nfet_03v3 ad=3.03p pd=7.2u as=3.03p ps=7.2u w=6u l=0.5u
X33 a_4186_430# a_1612_368# a_1612_368# X1.vdd.t3 pfet_03v3 ad=3.03p pd=7.2u as=3.03p ps=7.2u w=6u l=0.5u
X34 a_240_2922# X1.vdd VSUBS.t12 ppolyf_u_1k r_width=1u r_length=12u
X35 a_1612_368# a_1080_400# a_1424_368# VSUBS.t13 nfet_03v3 ad=3.03p pd=7.2u as=2.64p ps=12.88u w=6u l=0.5u
X36 a_29624_2016# a_29280_400# a_29280_400# VSUBS.t33 nfet_03v3 ad=3.03p pd=7.2u as=3.03p ps=7.2u w=6u l=0.5u
X37 a_4186_1878# a_1612_368# a_4374_1878# X1.vdd.t3 pfet_03v3 ad=3.03p pd=7.2u as=3.03p ps=7.2u w=6u l=0.5u
X38 a_4186_430# a_1612_368# a_1612_368# X1.vdd.t1 pfet_03v3 ad=3.03p pd=7.2u as=3.03p ps=7.2u w=6u l=0.5u
X39 VSUBS.t4 a_6130_536# a_6130_2884# VSUBS.t5 nfet_03v3 ad=2.64p pd=12.88u as=2.64p ps=12.88u w=6u l=5u
X40 a_34330_2884# REF a_32574_1878# VDD.t0 pfet_03v3 ad=8.294p pd=37.56u as=7.92p ps=36.88u w=18u l=5u
X41 a_1424_368# a_1080_400# a_1612_368# VSUBS.t16 nfet_03v3 ad=3.03p pd=7.2u as=3.03p ps=7.2u w=6u l=0.5u
X42 s2_out a_34330_2884# cap_mim_2f0_m4m5_noshield c_width=10u c_length=10u
X43 X1.vdd.t8 a_1612_368# a_4186_430# X1.vdd.t4 pfet_03v3 ad=2.64p pd=12.88u as=3.03p ps=7.2u w=6u l=2u
X44 a_4374_1878# s1_out a_6130_536# X1.vdd.t10 pfet_03v3 ad=7.92p pd=36.88u as=7.92p ps=36.88u w=18u l=5u
X45 a_24600_1640# a_27722_1360# VSUBS.t4 ppolyf_u_1k r_width=1u r_length=15u
X46 a_1424_368# a_1080_400# a_1612_368# VSUBS.t14 nfet_03v3 ad=3.03p pd=7.2u as=3.03p ps=7.2u w=6u l=0.5u
X47 a_4186_1878# a_1612_368# a_4374_1878# X1.vdd.t1 pfet_03v3 ad=3.03p pd=7.2u as=3.03p ps=7.2u w=6u l=0.5u
X48 a_1612_368# a_1612_368# a_4186_430# X1.vdd.t2 pfet_03v3 ad=3.03p pd=7.2u as=3.03p ps=7.2u w=6u l=0.5u
X49 a_24600_2760# a_27722_2480# VSUBS.t22 ppolyf_u_1k r_width=1u r_length=15u
X50 a_29624_2016# a_29280_400# VSUBS.t34 VSUBS.t33 nfet_03v3 ad=2.64p pd=12.88u as=3.03p ps=7.2u w=6u l=2u
X51 a_29624_368# a_29280_400# a_29812_368# VSUBS.t3 nfet_03v3 ad=3.03p pd=7.2u as=3.03p ps=7.2u w=6u l=0.5u
X52 a_29812_368# a_29812_368# a_32386_430# VDD.t3 pfet_03v3 ad=3.03p pd=7.2u as=3.03p ps=7.2u w=6u l=0.5u
X53 a_1080_400# a_1080_400# a_1424_2016# VSUBS.t15 nfet_03v3 ad=3.03p pd=7.2u as=3.03p ps=7.2u w=6u l=0.5u
X54 VSUBS.t20 a_1080_400# a_1424_368# VSUBS.t17 nfet_03v3 ad=2.64p pd=12.88u as=3.03p ps=7.2u w=6u l=2u
X55 VSUBS.t39 a_34330_2884# s2_out VSUBS.t38 nfet_03v3 ad=6.03p pd=13.2u as=6.03p ps=13.2u w=12u l=0.5u
X56 a_29812_368# a_29812_368# a_32386_430# VDD.t1 pfet_03v3 ad=3.03p pd=7.2u as=2.64p ps=12.88u w=6u l=0.5u
X57 a_24600_520# a_27722_800# VSUBS.t25 ppolyf_u_1k r_width=1u r_length=15u
X58 a_29812_368# a_29280_400# a_29624_368# VSUBS.t3 nfet_03v3 ad=3.03p pd=7.2u as=3.03p ps=7.2u w=6u l=0.5u
X59 a_32386_430# a_29812_368# a_29812_368# VDD.t4 pfet_03v3 ad=3.03p pd=7.2u as=3.03p ps=7.2u w=6u l=0.5u
X60 VSUBS.t29 a_34330_536# a_34330_536# VSUBS.t30 nfet_03v3 ad=2.64p pd=12.88u as=2.64p ps=12.88u w=6u l=5u
X61 a_800_2922# a_520_400# VSUBS.t28 ppolyf_u_1k r_width=1u r_length=12u
X62 a_28440_2922# VDD.t11 VSUBS.t23 ppolyf_u_1k r_width=1u r_length=12u
X63 a_29000_2922# a_28720_400# VSUBS.t23 ppolyf_u_1k r_width=1u r_length=12u
X64 VSUBS.t34 a_29280_400# a_29624_2016# VSUBS.t33 nfet_03v3 ad=3.03p pd=7.2u as=3.03p ps=7.2u w=6u l=2u
X65 s2_out a_34330_2884# VSUBS.t39 VSUBS.t40 nfet_03v3 ad=6.03p pd=13.2u as=6.03p ps=13.2u w=12u l=0.5u
X66 a_1080_400# a_1080_400# a_1424_2016# VSUBS.t13 nfet_03v3 ad=3.03p pd=7.2u as=2.64p ps=12.88u w=6u l=0.5u
X67 X1.vdd.t5 a_1612_368# a_4186_1878# X1.vdd.t4 pfet_03v3 ad=2.64p pd=12.88u as=3.03p ps=7.2u w=6u l=2u
X68 a_32386_430# a_29812_368# a_29812_368# VDD.t2 pfet_03v3 ad=3.03p pd=7.2u as=3.03p ps=7.2u w=6u l=0.5u
X69 a_29624_368# a_29280_400# a_29812_368# VSUBS.t3 nfet_03v3 ad=3.03p pd=7.2u as=3.03p ps=7.2u w=6u l=0.5u
X70 a_32574_1878# a_29812_368# a_32386_1878# VDD.t3 pfet_03v3 ad=3.03p pd=7.2u as=3.03p ps=7.2u w=6u l=0.5u
X71 s2_out a_34330_2884# VSUBS.t29 VSUBS.t37 nfet_03v3 ad=6.03p pd=13.2u as=5.28p ps=24.88u w=12u l=0.5u
X72 VDD.t7 a_29812_368# a_32386_430# VDD.t5 pfet_03v3 ad=2.64p pd=12.88u as=3.03p ps=7.2u w=6u l=2u
X73 a_32574_1878# s2_fb a_34330_536# VDD.t0 pfet_03v3 ad=7.92p pd=36.88u as=7.92p ps=36.88u w=18u l=5u
X74 s1_out a_6130_2884# cap_mim_2f0_m4m5_noshield c_width=10u c_length=10u
X75 VSUBS.t29 a_34330_2884# s2_out VSUBS.t41 nfet_03v3 ad=5.28p pd=24.88u as=6.03p ps=13.2u w=12u l=0.5u
X76 a_4374_1878# a_1612_368# a_4186_1878# X1.vdd.t2 pfet_03v3 ad=3.03p pd=7.2u as=3.03p ps=7.2u w=6u l=0.5u
X77 a_24600_1080# a_27722_1360# VSUBS.t26 ppolyf_u_1k r_width=1u r_length=15u
X78 VSUBS.t36 a_29280_400# a_29624_368# VSUBS.t3 nfet_03v3 ad=2.64p pd=12.88u as=3.03p ps=7.2u w=6u l=2u
X79 a_32574_1878# a_29812_368# a_32386_1878# VDD.t1 pfet_03v3 ad=3.03p pd=7.2u as=2.64p ps=12.88u w=6u l=0.5u
X80 s2_out OUTP VSUBS.t29 ppolyf_u_1k r_width=10u r_length=5u
X81 a_1424_2016# a_1080_400# a_1080_400# VSUBS.t16 nfet_03v3 ad=3.03p pd=7.2u as=3.03p ps=7.2u w=6u l=0.5u
X82 s1_out a_1612_368# X1.vdd.t7 X1.vdd.t6 pfet_03v3 ad=6.015p pd=13.1u as=5.28p ps=24.88u w=12u l=0.5u
X83 a_24600_2200# a_27722_2480# VSUBS.t7 ppolyf_u_1k r_width=1u r_length=15u
X84 a_29624_2016# a_29280_400# a_29280_400# VSUBS.t33 nfet_03v3 ad=3.03p pd=7.2u as=3.03p ps=7.2u w=6u l=0.5u
X85 a_6130_2884# SIG a_4374_1878# X1.vdd.t10 pfet_03v3 ad=8.294p pd=37.56u as=7.92p ps=36.88u w=18u l=5u
R0 VDD.t0 VDD.t8 721.385
R1 VDD.t5 VDD.n3 542.768
R2 VDD.t9 VDD.n0 0.477721
R3 VDD.n0 VDD.n3 1.42911
R4 VDD.n2 VDD.t6 3.51279
R5 VDD.n2 VDD.n1 3.3107
R6 VDD.t6 VDD.t0 160.377
R7 VDD.t4 VDD.t5 141.51
R8 VDD.n2 VDD.t1 105.242
R9 VDD.t10 VDD.t9 102.727
R10 VDD.t1 VDD.t2 94.3401
R11 VDD.t2 VDD.t3 94.3401
R12 VDD.t3 VDD.t4 94.3401
R13 VDD.t8 VDD.t10 94.3401
R14 VDD.t7 VDD.n1 0.0128555
R15 VDD.t11 VDD.n3 2.18881
R16 VDD VDD.t11 1.9475
R17 VDD.t6 VDD.n0 1.21843
R18 VDD.n3 VDD.n1 1.08202
R19 VSUBS.n8 VSUBS.n9 82671.9
R20 VSUBS.n10 VSUBS.n9 82671.9
R21 VSUBS.n12 VSUBS.n6 82671.9
R22 VSUBS.n13 VSUBS.n7 82671.9
R23 VSUBS.n8 VSUBS.n13 61546.9
R24 VSUBS.n12 VSUBS.n10 61546.9
R25 VSUBS.n6 VSUBS.n11 61546.9
R26 VSUBS.n11 VSUBS.n7 61546.9
R27 VSUBS.t30 VSUBS.t37 770.715
R28 VSUBS.n9 VSUBS.t30 679.715
R29 VSUBS.n10 VSUBS.n2 2.07832
R30 VSUBS.n8 VSUBS.n1 597.101
R31 VSUBS.n5 VSUBS.n3 2.65579
R32 VSUBS.n4 VSUBS.n3 2.16804
R33 VSUBS.n8 VSUBS.t29 2.98196
R34 VSUBS.n0 VSUBS.t29 1.397
R35 VSUBS.n6 VSUBS.t4 3.02006
R36 VSUBS.t17 VSUBS.t19 557.144
R37 VSUBS.t16 VSUBS.t17 417.858
R38 VSUBS.t19 VSUBS.n11 360.286
R39 VSUBS.t27 VSUBS.t13 354.714
R40 VSUBS.t37 VSUBS.t38 278.572
R41 VSUBS.t38 VSUBS.t40 278.572
R42 VSUBS.t40 VSUBS.t41 278.572
R43 VSUBS.t13 VSUBS.t14 278.572
R44 VSUBS.t14 VSUBS.t15 278.572
R45 VSUBS.t15 VSUBS.t16 278.572
R46 VSUBS.n3 VSUBS.t12 269.44
R47 VSUBS.t41 VSUBS.t29 267.43
R48 VSUBS.t12 VSUBS.t6 260
R49 VSUBS.t6 VSUBS.t28 260
R50 VSUBS.t28 VSUBS.t27 260
R51 VSUBS.t0 VSUBS.t32 43.1285
R52 VSUBS.t25 VSUBS.t0 43.1285
R53 VSUBS.t26 VSUBS.t2 43.1285
R54 VSUBS.t21 VSUBS.t1 43.1285
R55 VSUBS.t24 VSUBS.t22 43.1285
R56 VSUBS.n13 VSUBS.t24 43.1285
R57 VSUBS.t23 VSUBS.t26 40.356
R58 VSUBS.t32 VSUBS.n12 40.0479
R59 VSUBS.t1 VSUBS.t8 38.8157
R60 VSUBS.t22 VSUBS.t33 37.5834
R61 VSUBS.t2 VSUBS.t3 32.6545
R62 VSUBS.t5 VSUBS.t21 27.1095
R63 VSUBS.t7 VSUBS.t5 16.0195
R64 VSUBS.t3 VSUBS.t25 10.4744
R65 VSUBS VSUBS.n14 5.8405
R66 VSUBS.t33 VSUBS.t7 5.54552
R67 VSUBS.n10 VSUBS.n0 3.01746
R68 VSUBS.n7 VSUBS.t4 3.49194
R69 VSUBS.t4 VSUBS.t23 2.77301
R70 VSUBS.t8 VSUBS.n1 2.77301
R71 VSUBS.n2 VSUBS.n1 2.65579
R72 VSUBS.n1 VSUBS.t4 2.43201
R73 VSUBS.t20 VSUBS.n5 0.0103098
R74 VSUBS.t34 VSUBS.n8 2.37129
R75 VSUBS.n4 VSUBS.n7 2.35385
R76 VSUBS.n4 VSUBS.t18 0.00960425
R77 VSUBS.n2 VSUBS.t36 0.0103098
R78 VSUBS.n6 VSUBS.n5 2.07832
R79 VSUBS.n0 VSUBS.t39 0.00816412
R80 VSUBS.n14 VSUBS.t34 1.2605
R81 VSUBS.n14 VSUBS.n1 1.07701
R82 X1.vdd.t10 X1.vdd.t6 721.385
R83 X1.vdd.n2 X1.vdd.t4 542.768
R84 X1.vdd.n0 X1.vdd.n2 1.42911
R85 X1.vdd.n0 X1.vdd.t7 0.477721
R86 X1.vdd.t5 X1.vdd.t10 160.377
R87 X1.vdd.t4 X1.vdd.t3 141.51
R88 X1.vdd.t0 X1.vdd.n1 105.031
R89 X1.vdd.t9 X1.vdd.t7 102.727
R90 X1.vdd.t1 X1.vdd.t0 94.3401
R91 X1.vdd.t2 X1.vdd.t1 94.3401
R92 X1.vdd.t3 X1.vdd.t2 94.3401
R93 X1.vdd.t6 X1.vdd.t9 94.3401
R94 X1.vdd.n1 X1.vdd.n3 28.3024
R95 X1.vdd.t5 X1.vdd.n1 3.72808
R96 X1.vdd.n1 X1.vdd.t8 3.3107
R97 X1.vdd.t5 X1.vdd.n0 2.19817
R98 X1.vdd X1.vdd.n2 2.18881
R99 X1.vdd.n2 X1.vdd.t8 1.08202
C0 a_24600_1080# s1_out 0.00112f
C1 s2_fb REF 0.21873f
C2 m2_52400_0# s2_out 0.02002f
C3 a_4186_430# a_1612_368# 3.56144f
C4 VDD a_27722_800# 0.00303f
C5 a_32386_430# a_34330_2884# 0.07455f
C6 VDD a_24600_520# 0.00465f
C7 a_24600_1640# VDD 0
C8 a_4186_430# a_4186_1878# 0.02111f
C9 VDD s2_fb 2.65043f
C10 a_1612_368# a_1424_368# 2.27244f
C11 a_29624_2016# s2_fb 0.02361f
C12 s2_out a_34330_2884# 10.7489f
C13 SIG a_1612_368# 0.26401f
C14 a_1424_2016# X1.vdd 0.56148f
C15 a_32386_1878# a_34330_2884# 0.09274f
C16 a_34330_536# a_32574_1878# 0.1647f
C17 a_240_2922# a_1424_2016# 0.0036f
C18 a_27722_800# s2_fb 0.09349f
C19 a_4186_1878# SIG 0.02072f
C20 a_32386_430# a_29812_368# 3.56144f
C21 a_4186_430# X1.vdd 1.93212f
C22 a_27722_1360# a_27722_1920# 0.07722f
C23 a_32386_430# a_29280_400# 0.00683f
C24 a_27722_1360# s2_out 0.00149f
C25 a_32386_430# a_29624_368# 0.00137f
C26 a_4186_1878# a_1612_368# 1.60167f
C27 a_4374_1878# a_4186_430# 0.02895f
C28 s2_out a_29812_368# 1.46301f
C29 a_520_400# X1.vdd 0.0937f
C30 a_34330_2884# REF 1.28056f
C31 X1.vdd a_1424_368# 0.34118f
C32 s2_out a_28440_2922# 0.02744f
C33 a_32386_1878# a_29812_368# 1.60167f
C34 SIG X1.vdd 1.84984f
C35 a_27722_1920# a_29280_400# 0
C36 s2_out a_29280_400# 0.09363f
C37 a_1080_400# a_800_2922# 0.00522f
C38 a_24600_2200# a_24600_2760# 0.06564f
C39 s2_out a_29624_368# 0.00173f
C40 a_29000_2922# a_28440_2922# 0.06564f
C41 a_32386_1878# a_29280_400# 0
C42 a_4374_1878# SIG 1.04102f
C43 a_29000_2922# a_29280_400# 0.00522f
C44 a_27722_1920# a_27722_2480# 0.07722f
C45 a_1612_368# X1.vdd 7.07798f
C46 s2_out a_27722_2480# 0.11052f
C47 VDD a_34330_2884# 5.54595f
C48 a_34330_536# a_32386_430# 0.00418f
C49 a_32574_1878# a_32386_430# 0.02895f
C50 a_29812_368# REF 0.2631f
C51 a_4374_1878# a_1612_368# 1.50907f
C52 a_4186_1878# X1.vdd 1.56751f
C53 a_4374_1878# a_4186_1878# 2.7956f
C54 a_27722_1360# VDD 0.00104f
C55 a_34330_536# s2_out 2.38517f
C56 a_32574_1878# s2_out 1.51937f
C57 m2_52400_0# OUTP 0.22538f
C58 s2_fb a_34330_2884# 0.5473f
C59 VDD a_29812_368# 7.07798f
C60 a_4186_430# a_6130_536# 0.00418f
C61 a_29624_2016# a_29812_368# 0.71887f
C62 a_1424_2016# a_1080_400# 4.5475f
C63 a_32386_1878# a_32574_1878# 2.7956f
C64 a_4186_430# s1_out 0.11633f
C65 VDD a_29280_400# 0.23759f
C66 a_29624_2016# a_28440_2922# 0.0036f
C67 a_27722_1360# a_27722_800# 0.07722f
C68 a_29624_368# VDD 0.34118f
C69 a_29624_2016# a_29280_400# 4.5475f
C70 a_4374_1878# X1.vdd 2.37732f
C71 a_29624_368# a_29624_2016# 0.00526f
C72 VDD s1_out 0.11068f
C73 a_4186_430# a_6130_2884# 0.09484f
C74 a_4186_430# a_1080_400# 0.00683f
C75 SIG a_6130_536# 0.01618f
C76 a_27722_800# a_29280_400# 0
C77 s2_fb a_29812_368# 1.33902f
C78 SIG s1_out 1.51788f
C79 a_34330_536# REF 0.01288f
C80 a_32574_1878# REF 1.04102f
C81 a_520_400# a_1080_400# 0.07233f
C82 a_24600_520# s1_out 0.09666f
C83 s2_fb a_29280_400# 0.23f
C84 a_1080_400# a_1424_368# 1.66376f
C85 a_6130_536# a_1612_368# 0.05752f
C86 a_24600_1640# s1_out 0
C87 a_6130_2884# SIG 1.48243f
C88 a_29624_368# s2_fb 0.12496f
C89 a_1612_368# s1_out 0.98991f
C90 a_24600_1080# VDD 0.00151f
C91 s2_out a_32386_430# 0.09614f
C92 a_34330_536# VDD 4.80044f
C93 a_32574_1878# VDD 2.37732f
C94 a_28720_400# VDD 0.0937f
C95 a_4186_1878# s1_out 0.05205f
C96 a_6130_2884# a_1612_368# 1.20696f
C97 a_32386_1878# a_32386_430# 0.02111f
C98 a_1080_400# a_1612_368# 1.34038f
C99 a_24600_1080# a_24600_520# 0.06564f
C100 a_27722_1920# s2_out 0.00421f
C101 a_6130_2884# a_4186_1878# 0.14645f
C102 a_24600_1080# a_24600_1640# 0.06564f
C103 a_4186_1878# a_1080_400# 0
C104 a_1424_2016# a_800_2922# 0.07166f
C105 a_32386_1878# s2_out 0.84169f
C106 a_29000_2922# s2_out 0.02361f
C107 a_34330_536# s2_fb 1.56054f
C108 a_6130_536# X1.vdd 4.77556f
C109 a_32574_1878# s2_fb 1.02019f
C110 a_28720_400# s2_fb 0.0148f
C111 s1_out X1.vdd 6.14171f
C112 a_4374_1878# a_6130_536# 0.1647f
C113 a_34330_2884# a_29812_368# 1.11045f
C114 a_4374_1878# s1_out 2.21577f
C115 a_6130_2884# X1.vdd 5.55769f
C116 a_1080_400# X1.vdd 0.23759f
C117 s2_out REF 1.94957f
C118 a_32386_430# VDD 1.93212f
C119 a_4374_1878# a_6130_2884# 0.46766f
C120 a_4374_1878# a_1080_400# 0
C121 a_32386_1878# REF 0.02072f
C122 s2_out VDD 4.18761f
C123 a_27722_1360# a_29280_400# 0
C124 s2_out a_29624_2016# 1.75218f
C125 a_29280_400# a_29812_368# 1.34038f
C126 a_32386_1878# VDD 1.56751f
C127 a_32386_430# s2_fb 0.64114f
C128 a_29624_368# a_29812_368# 2.27244f
C129 a_29000_2922# a_29624_2016# 0.07166f
C130 s2_out a_27722_800# 0
C131 a_34330_536# a_34330_2884# 0.93277f
C132 a_32574_1878# a_34330_2884# 0.44128f
C133 a_29624_368# a_29280_400# 1.66376f
C134 s2_out s2_fb 3.63739f
C135 a_27722_2480# a_28440_2922# 0
C136 a_6130_536# s1_out 3.47924f
C137 a_1424_2016# a_1424_368# 0.00526f
C138 VDD REF 1.84474f
C139 a_32386_1878# s2_fb 0.00607f
C140 a_24600_1640# a_24600_2200# 0.06564f
C141 a_6130_2884# a_6130_536# 0.91681f
C142 a_34330_536# a_29812_368# 0.06012f
C143 a_6130_2884# s1_out 6.93821f
C144 OUTP s2_out 0.14427f
C145 a_32574_1878# a_29812_368# 1.50907f
C146 a_240_2922# a_800_2922# 0.06564f
C147 a_4186_430# a_1424_368# 0.00137f
C148 a_1424_2016# a_1612_368# 0.71887f
C149 a_29624_2016# VDD 0.56148f
C150 a_32574_1878# a_29280_400# 0
C151 a_28720_400# a_29280_400# 0.07233f
C152 OUTP VSUBS 3.66606f
C153 VDD VSUBS 88.98413f
C154 m2_52400_0# VSUBS 1.14802f ; **FLOATING
C155 a_34330_536# VSUBS 1.4954f
C156 a_32386_430# VSUBS 0.05612f
C157 a_32386_1878# VSUBS 1.3692f
C158 a_32574_1878# VSUBS 2.93915f
C159 a_29624_368# VSUBS 1.55522f
C160 a_29000_2922# VSUBS 0.82448f
C161 a_28720_400# VSUBS 0.81216f
C162 a_28440_2922# VSUBS 0.90167f
C163 a_29624_2016# VSUBS 5.19039f
C164 a_24600_520# VSUBS 0.48955f
C165 a_27722_800# VSUBS 0.51194f
C166 a_24600_1080# VSUBS 0.48914f
C167 a_27722_1360# VSUBS 0.5114f
C168 a_24600_1640# VSUBS 0.48917f
C169 a_27722_1920# VSUBS 0.51162f
C170 a_24600_2200# VSUBS 0.48974f
C171 a_27722_2480# VSUBS 0.5117f
C172 s2_out VSUBS 13.93987f
C173 a_24600_2760# VSUBS 0.53259f
C174 a_6130_536# VSUBS 4.97503f
C175 a_4186_430# VSUBS 0.05612f
C176 a_6130_2884# VSUBS 0.06239f
C177 a_4186_1878# VSUBS 0.01223f
C178 a_4374_1878# VSUBS 5.07391f
C179 a_1424_368# VSUBS 1.55522f
C180 a_800_2922# VSUBS 0.82448f
C181 a_520_400# VSUBS 0.81216f
C182 a_240_2922# VSUBS 0.90259f
C183 a_1424_2016# VSUBS 5.19732f
C184 X1.vdd VSUBS 87.99497f
C185 X1.vdd.t5 VSUBS 2.43228f
C186 X1.vdd.t7 VSUBS 4.8207f
C187 X1.vdd.t8 VSUBS 0.59563f
C188 X1.vdd.n1 VSUBS 1.36865f
C189 X1.vdd.n2 VSUBS 6.32603f
C190 X1.vdd.t9 VSUBS 0.98123f
C191 X1.vdd.t6 VSUBS 4.05772f
C192 X1.vdd.t10 VSUBS 4.38621f
C193 X1.vdd.n3 VSUBS 0.14078f
C194 X1.vdd.t0 VSUBS 0.99175f
C195 X1.vdd.t1 VSUBS 0.93856f
C196 X1.vdd.t2 VSUBS 0.93856f
C197 X1.vdd.t3 VSUBS 1.1732f
C198 X1.vdd.t4 VSUBS 3.40385f
C199 VSUBS.t4 VSUBS 11.60403f
C200 VSUBS.t29 VSUBS 1.65398f
C201 VSUBS.t39 VSUBS 13.93987f
C202 VDD.t6 VSUBS 2.44768f
C203 VDD.t9 VSUBS 3.48565f
C204 VDD.n2 VSUBS 1.51737f
C205 VDD.n3 VSUBS 6.36606f
C206 VDD.t7 VSUBS 0.5994f
C207 VDD.t10 VSUBS 0.98744f
C208 VDD.t8 VSUBS 4.0834f
C209 VDD.t0 VSUBS 4.41397f
C210 VDD.t5 VSUBS 3.42539f
C211 VDD.t4 VSUBS 1.18063f
C212 VDD.t3 VSUBS 0.9445f
C213 VDD.t2 VSUBS 0.9445f
C214 VDD.t1 VSUBS 0.99964f
C215 VDD.t11 VSUBS 1.56734f
.ends
