* NGSPICE file created from ip_sigproc_parax.ext - technology: gf180mcuD

.subckt ip_sigproc_parax VSUBS OUTP VDD SIG REF
X0 a_24600_2200# a_27722_1920# VSUBS.t34 ppolyf_u_1k r_width=1u r_length=15u
X1 a_24600_520# s2_fb VSUBS.t36 ppolyf_u_1k r_width=1u r_length=15u
X2 VDD.t10 a_1612_368# s1_out VDD.t12 pfet_03v3 ad=5.28p pd=24.88u as=6.015p ps=13.1u w=12u l=0.5u
X3 a_1424_2016# a_1080_400# a_1080_400# VSUBS.t17 nfet_03v3 ad=3.03p pd=7.2u as=3.03p ps=7.2u w=6u l=0.5u
X4 s1_out w_13700_140# cap_pmos_03v3 c_width=13.5u c_length=18u
X5 a_32386_1878# a_29812_368# a_32574_1878# VDD.t16 pfet_03v3 ad=3.03p pd=7.2u as=3.03p ps=7.2u w=6u l=0.5u
X6 a_29000_2922# a_29280_400# VSUBS.t0 ppolyf_u_1k r_width=1u r_length=12u
X7 a_1424_2016# a_1080_400# VSUBS.t21 VSUBS.t22 nfet_03v3 ad=2.64p pd=12.88u as=3.03p ps=7.2u w=6u l=2u
X8 a_240_2922# a_520_400# VSUBS.t29 ppolyf_u_1k r_width=1u r_length=12u
X9 s1_out a_6130_2884# VSUBS.t25 VSUBS.t24 nfet_03v3 ad=6.03p pd=13.2u as=6.03p ps=13.2u w=12u l=0.5u
X10 a_800_2922# a_1080_400# VSUBS.t39 ppolyf_u_1k r_width=1u r_length=12u
X11 a_47720_2942# w_41900_140# w_41900_140# ppolyf_u_1k r_width=1u r_length=12u
X12 a_32386_1878# a_29812_368# a_32574_1878# VDD.t14 pfet_03v3 ad=3.03p pd=7.2u as=3.03p ps=7.2u w=6u l=0.5u
X13 s1_out a_6130_2884# VSUBS.t25 VSUBS.t24 nfet_03v3 ad=6.03p pd=13.2u as=5.28p ps=24.88u w=12u l=0.5u
X14 a_47160_2942# a_47440_420# w_41900_140# ppolyf_u_1k r_width=1u r_length=12u
X15 s2_out a_29812_368# VDD.t21 VDD.t20 pfet_03v3 ad=6.015p pd=13.1u as=5.28p ps=24.88u w=12u l=0.5u
X16 a_24600_1080# a_27722_800# VSUBS.t35 ppolyf_u_1k r_width=1u r_length=15u
X17 a_19520_2942# a_19240_420# w_13700_140# ppolyf_u_1k r_width=1u r_length=12u
X18 VSUBS.t21 a_1080_400# a_1424_2016# VSUBS.t20 nfet_03v3 ad=3.03p pd=7.2u as=3.03p ps=7.2u w=6u l=2u
X19 a_29280_400# a_29280_400# a_29624_2016# VSUBS.t7 nfet_03v3 ad=3.03p pd=7.2u as=3.03p ps=7.2u w=6u l=0.5u
X20 a_46600_2942# a_46880_420# w_41900_140# ppolyf_u_1k r_width=1u r_length=12u
X21 a_18960_2942# a_18680_420# w_13700_140# ppolyf_u_1k r_width=1u r_length=12u
X22 VSUBS.t25 a_6130_2884# s1_out VSUBS.t24 nfet_03v3 ad=5.28p pd=24.88u as=6.03p ps=13.2u w=12u l=0.5u
X23 a_46040_2942# a_46320_420# w_41900_140# ppolyf_u_1k r_width=1u r_length=12u
X24 a_18400_2942# a_18120_420# w_13700_140# ppolyf_u_1k r_width=1u r_length=12u
X25 a_24600_1640# a_27722_1920# VSUBS.t4 ppolyf_u_1k r_width=1u r_length=15u
X26 VSUBS.t2 a_34330_536# a_34330_2884# VSUBS.t1 nfet_03v3 ad=2.64p pd=12.88u as=2.64p ps=12.88u w=6u l=5u
X27 a_17840_2942# VDD.t25 w_13700_140# ppolyf_u_1k r_width=1u r_length=12u
X28 VSUBS.t25 a_6130_2884# s1_out VSUBS.t24 nfet_03v3 ad=6.03p pd=13.2u as=6.03p ps=13.2u w=12u l=0.5u
X29 VDD.t21 a_29812_368# s2_out VDD.t22 pfet_03v3 ad=5.28p pd=24.88u as=6.015p ps=13.1u w=12u l=0.5u
X30 a_6130_2884# w_13700_140# cap_pmos_03v3 c_width=13.5u c_length=18u
X31 VDD.t18 a_29812_368# a_32386_1878# VDD.t17 pfet_03v3 ad=2.64p pd=12.88u as=3.03p ps=7.2u w=6u l=2u
X32 s1_out s2_fb VSUBS.t43 ppolyf_u_1k r_width=1u r_length=15u
X33 a_24600_2760# s2_out VSUBS.t38 ppolyf_u_1k r_width=1u r_length=15u
X34 a_4374_1878# a_1612_368# a_4186_1878# VDD.t3 pfet_03v3 ad=3.03p pd=7.2u as=2.64p ps=12.88u w=6u l=0.5u
X35 a_28440_2922# a_28720_400# VSUBS.t0 ppolyf_u_1k r_width=1u r_length=12u
X36 s2_out w_41900_140# cap_pmos_03v3 c_width=13.5u c_length=18u
X37 a_29812_368# a_29280_400# a_29624_368# VSUBS.t10 nfet_03v3 ad=3.03p pd=7.2u as=2.64p ps=12.88u w=6u l=0.5u
X38 a_1612_368# a_1612_368# a_4186_430# VDD.t3 pfet_03v3 ad=3.03p pd=7.2u as=2.64p ps=12.88u w=6u l=0.5u
X39 VSUBS.t25 a_6130_536# a_6130_536# VSUBS.t33 nfet_03v3 ad=2.64p pd=12.88u as=2.64p ps=12.88u w=6u l=5u
X40 a_29280_400# a_29280_400# a_29624_2016# VSUBS.t7 nfet_03v3 ad=3.03p pd=7.2u as=2.64p ps=12.88u w=6u l=0.5u
X41 a_1612_368# a_1080_400# a_1424_368# VSUBS.t18 nfet_03v3 ad=3.03p pd=7.2u as=3.03p ps=7.2u w=6u l=0.5u
X42 a_4186_430# a_1612_368# a_1612_368# VDD.t6 pfet_03v3 ad=3.03p pd=7.2u as=3.03p ps=7.2u w=6u l=0.5u
X43 a_29624_2016# a_29280_400# a_29280_400# VSUBS.t7 nfet_03v3 ad=3.03p pd=7.2u as=3.03p ps=7.2u w=6u l=0.5u
X44 a_240_2922# VDD.t24 VSUBS.t31 ppolyf_u_1k r_width=1u r_length=12u
X45 a_1612_368# a_1080_400# a_1424_368# VSUBS.t16 nfet_03v3 ad=3.03p pd=7.2u as=2.64p ps=12.88u w=6u l=0.5u
X46 a_4186_1878# a_1612_368# a_4374_1878# VDD.t6 pfet_03v3 ad=3.03p pd=7.2u as=3.03p ps=7.2u w=6u l=0.5u
X47 a_4186_430# a_1612_368# a_1612_368# VDD.t4 pfet_03v3 ad=3.03p pd=7.2u as=3.03p ps=7.2u w=6u l=0.5u
X48 a_34330_2884# REF a_32574_1878# VDD.t2 pfet_03v3 ad=8.294p pd=37.56u as=7.92p ps=36.88u w=18u l=5u
X49 VSUBS.t25 a_6130_536# a_6130_2884# VSUBS.t32 nfet_03v3 ad=2.64p pd=12.88u as=2.64p ps=12.88u w=6u l=5u
X50 a_1424_368# a_1080_400# a_1612_368# VSUBS.t19 nfet_03v3 ad=3.03p pd=7.2u as=3.03p ps=7.2u w=6u l=0.5u
X51 a_24600_1640# a_27722_1360# VSUBS.t42 ppolyf_u_1k r_width=1u r_length=15u
X52 VDD.t11 a_1612_368# a_4186_430# VDD.t7 pfet_03v3 ad=2.64p pd=12.88u as=3.03p ps=7.2u w=6u l=2u
X53 a_34330_2884# w_41900_140# cap_pmos_03v3 c_width=13.5u c_length=18u
X54 a_47160_2942# a_46880_420# w_41900_140# ppolyf_u_1k r_width=1u r_length=12u
X55 a_18960_2942# a_19240_420# w_13700_140# ppolyf_u_1k r_width=1u r_length=12u
X56 a_4374_1878# s1_out a_6130_536# VDD.t1 pfet_03v3 ad=7.92p pd=36.88u as=7.92p ps=36.88u w=18u l=5u
X57 a_29624_368# a_29280_400# a_29812_368# VSUBS.t10 nfet_03v3 ad=3.03p pd=7.2u as=3.03p ps=7.2u w=6u l=0.5u
X58 a_18400_2942# a_18680_420# w_13700_140# ppolyf_u_1k r_width=1u r_length=12u
X59 a_1424_368# a_1080_400# a_1612_368# VSUBS.t17 nfet_03v3 ad=3.03p pd=7.2u as=3.03p ps=7.2u w=6u l=0.5u
X60 a_24600_2760# a_27722_2480# VSUBS.t5 ppolyf_u_1k r_width=1u r_length=15u
X61 a_29812_368# a_29812_368# a_32386_430# VDD.t15 pfet_03v3 ad=3.03p pd=7.2u as=3.03p ps=7.2u w=6u l=0.5u
X62 a_1612_368# a_1612_368# a_4186_430# VDD.t5 pfet_03v3 ad=3.03p pd=7.2u as=3.03p ps=7.2u w=6u l=0.5u
X63 a_29624_2016# a_29280_400# VSUBS.t8 VSUBS.t7 nfet_03v3 ad=2.64p pd=12.88u as=3.03p ps=7.2u w=6u l=2u
X64 a_4186_1878# a_1612_368# a_4374_1878# VDD.t4 pfet_03v3 ad=3.03p pd=7.2u as=3.03p ps=7.2u w=6u l=0.5u
X65 a_46040_2942# VDD.t23 w_41900_140# ppolyf_u_1k r_width=1u r_length=12u
X66 a_17840_2942# a_18120_420# w_13700_140# ppolyf_u_1k r_width=1u r_length=12u
X67 VSUBS.t2 a_34330_2884# s2_out VSUBS.t12 nfet_03v3 ad=6.03p pd=13.2u as=6.03p ps=13.2u w=12u l=0.5u
X68 a_1080_400# a_1080_400# a_1424_2016# VSUBS.t18 nfet_03v3 ad=3.03p pd=7.2u as=3.03p ps=7.2u w=6u l=0.5u
X69 VSUBS.t23 a_1080_400# a_1424_368# VSUBS.t20 nfet_03v3 ad=2.64p pd=12.88u as=3.03p ps=7.2u w=6u l=2u
X70 a_29812_368# a_29812_368# a_32386_430# VDD.t13 pfet_03v3 ad=3.03p pd=7.2u as=2.64p ps=12.88u w=6u l=0.5u
X71 VSUBS.t2 a_34330_536# a_34330_536# VSUBS.t3 nfet_03v3 ad=2.64p pd=12.88u as=2.64p ps=12.88u w=6u l=5u
X72 a_29812_368# a_29280_400# a_29624_368# VSUBS.t10 nfet_03v3 ad=3.03p pd=7.2u as=3.03p ps=7.2u w=6u l=0.5u
X73 a_24600_520# a_27722_800# VSUBS.t6 ppolyf_u_1k r_width=1u r_length=15u
X74 a_32386_430# a_29812_368# a_29812_368# VDD.t16 pfet_03v3 ad=3.03p pd=7.2u as=3.03p ps=7.2u w=6u l=0.5u
X75 a_29000_2922# a_28720_400# VSUBS.t0 ppolyf_u_1k r_width=1u r_length=12u
X76 a_800_2922# a_520_400# VSUBS.t37 ppolyf_u_1k r_width=1u r_length=12u
X77 s2_out a_34330_2884# VSUBS.t2 VSUBS.t12 nfet_03v3 ad=6.03p pd=13.2u as=6.03p ps=13.2u w=12u l=0.5u
X78 VSUBS.t8 a_29280_400# a_29624_2016# VSUBS.t7 nfet_03v3 ad=3.03p pd=7.2u as=3.03p ps=7.2u w=6u l=2u
X79 a_28440_2922# VDD.t0 VSUBS.t0 ppolyf_u_1k r_width=1u r_length=12u
X80 a_32386_430# a_29812_368# a_29812_368# VDD.t14 pfet_03v3 ad=3.03p pd=7.2u as=3.03p ps=7.2u w=6u l=0.5u
X81 a_1080_400# a_1080_400# a_1424_2016# VSUBS.t16 nfet_03v3 ad=3.03p pd=7.2u as=2.64p ps=12.88u w=6u l=0.5u
X82 VDD.t8 a_1612_368# a_4186_1878# VDD.t7 pfet_03v3 ad=2.64p pd=12.88u as=3.03p ps=7.2u w=6u l=2u
X83 a_32574_1878# a_29812_368# a_32386_1878# VDD.t15 pfet_03v3 ad=3.03p pd=7.2u as=3.03p ps=7.2u w=6u l=0.5u
X84 s2_out a_34330_2884# VSUBS.t2 VSUBS.t12 nfet_03v3 ad=6.03p pd=13.2u as=5.28p ps=24.88u w=12u l=0.5u
X85 a_29624_368# a_29280_400# a_29812_368# VSUBS.t10 nfet_03v3 ad=3.03p pd=7.2u as=3.03p ps=7.2u w=6u l=0.5u
X86 a_47720_2942# a_47440_420# w_41900_140# ppolyf_u_1k r_width=1u r_length=12u
X87 a_19520_2942# w_13700_140# w_13700_140# ppolyf_u_1k r_width=1u r_length=12u
X88 VDD.t19 a_29812_368# a_32386_430# VDD.t17 pfet_03v3 ad=2.64p pd=12.88u as=3.03p ps=7.2u w=6u l=2u
X89 a_32574_1878# s2_fb a_34330_536# VDD.t2 pfet_03v3 ad=7.92p pd=36.88u as=7.92p ps=36.88u w=18u l=5u
X90 VSUBS.t2 a_34330_2884# s2_out VSUBS.t12 nfet_03v3 ad=5.28p pd=24.88u as=6.03p ps=13.2u w=12u l=0.5u
X91 a_46600_2942# a_46320_420# w_41900_140# ppolyf_u_1k r_width=1u r_length=12u
X92 a_24600_1080# a_27722_1360# VSUBS.t40 ppolyf_u_1k r_width=1u r_length=15u
X93 s2_out OUTP VSUBS.t41 ppolyf_u_1k r_width=10u r_length=5u
X94 a_4374_1878# a_1612_368# a_4186_1878# VDD.t5 pfet_03v3 ad=3.03p pd=7.2u as=3.03p ps=7.2u w=6u l=0.5u
X95 a_32574_1878# a_29812_368# a_32386_1878# VDD.t13 pfet_03v3 ad=3.03p pd=7.2u as=2.64p ps=12.88u w=6u l=0.5u
X96 VSUBS.t11 a_29280_400# a_29624_368# VSUBS.t10 nfet_03v3 ad=2.64p pd=12.88u as=3.03p ps=7.2u w=6u l=2u
X97 a_24600_2200# a_27722_2480# VSUBS.t30 ppolyf_u_1k r_width=1u r_length=15u
X98 s1_out a_1612_368# VDD.t10 VDD.t9 pfet_03v3 ad=6.015p pd=13.1u as=5.28p ps=24.88u w=12u l=0.5u
X99 a_1424_2016# a_1080_400# a_1080_400# VSUBS.t19 nfet_03v3 ad=3.03p pd=7.2u as=3.03p ps=7.2u w=6u l=0.5u
X100 a_29624_2016# a_29280_400# a_29280_400# VSUBS.t7 nfet_03v3 ad=3.03p pd=7.2u as=3.03p ps=7.2u w=6u l=0.5u
X101 a_6130_2884# SIG a_4374_1878# VDD.t1 pfet_03v3 ad=8.294p pd=37.56u as=7.92p ps=36.88u w=18u l=5u
R0 VDD.t2 VDD.t20 721.385
R1 VDD.t1 VDD.t9 721.385
R2 VDD.t17 VDD.t23 542.768
R3 VDD.t7 VDD.t24 542.768
R4 VDD.t21 VDD.n1 0.477721
R5 VDD.t10 VDD.n0 0.477721
R6 VDD.n1 VDD.t23 1.42911
R7 VDD.n2 VDD.t18 3.51279
R8 VDD.n0 VDD.t24 1.42911
R9 VDD.n3 VDD.t8 3.51279
R10 VDD.t18 VDD.t2 160.377
R11 VDD.t8 VDD.t1 160.377
R12 VDD.t16 VDD.t17 141.51
R13 VDD.t6 VDD.t7 141.51
R14 VDD.n2 VDD.t13 105.242
R15 VDD.n3 VDD.t3 105.242
R16 VDD.t22 VDD.t21 102.727
R17 VDD.t12 VDD.t10 102.727
R18 VDD.t13 VDD.t14 94.3401
R19 VDD.t14 VDD.t15 94.3401
R20 VDD.t15 VDD.t16 94.3401
R21 VDD.t20 VDD.t22 94.3401
R22 VDD.t3 VDD.t4 94.3401
R23 VDD.t4 VDD.t5 94.3401
R24 VDD.t5 VDD.t6 94.3401
R25 VDD.t9 VDD.t12 94.3401
R26 VDD.t19 VDD.n2 3.30996
R27 VDD.t11 VDD.n3 3.30996
R28 VDD.t25 VDD.t24 3.1625
R29 VDD VDD.t25 2.25725
R30 VDD.t0 VDD.t23 2.1185
R31 VDD VDD.t0 1.9475
R32 VDD.t18 VDD.n1 1.21843
R33 VDD.t8 VDD.n0 1.21843
R34 VDD.t19 VDD.t23 1.15107
R35 VDD.t11 VDD.t24 1.15107
R36 VSUBS.n25 VSUBS.n24 242826
R37 VSUBS.n27 VSUBS.n26 242826
R38 VSUBS.n23 VSUBS.n22 242821
R39 VSUBS.n22 VSUBS.n12 242821
R40 VSUBS.n27 VSUBS.n16 144219
R41 VSUBS.n24 VSUBS.n20 144219
R42 VSUBS.n19 VSUBS.n18 144219
R43 VSUBS.n18 VSUBS.n17 144219
R44 VSUBS.n20 VSUBS.t1 1136.3
R45 VSUBS.n19 VSUBS.t32 1136.3
R46 VSUBS.t3 VSUBS.n16 1068.89
R47 VSUBS.t33 VSUBS.n17 1068.89
R48 VSUBS.t12 VSUBS.t3 962.963
R49 VSUBS.t24 VSUBS.t33 962.963
R50 VSUBS.n0 VSUBS.n10 2.63494
R51 VSUBS.t1 VSUBS.t12 852.222
R52 VSUBS.t32 VSUBS.t24 852.222
R53 VSUBS.t25 VSUBS.n14 847
R54 VSUBS.t2 VSUBS.n11 847
R55 VSUBS.t2 VSUBS.n7 847
R56 VSUBS.t25 VSUBS.n15 847
R57 VSUBS.t2 VSUBS.n13 847
R58 VSUBS.t2 VSUBS.n8 847
R59 VSUBS.n9 VSUBS.t41 824.725
R60 VSUBS.n5 VSUBS.t41 754
R61 VSUBS.t22 VSUBS.t20 557.144
R62 VSUBS.t20 VSUBS.t19 417.858
R63 VSUBS.n18 VSUBS.t22 360.286
R64 VSUBS.t16 VSUBS.t39 354.714
R65 VSUBS.n11 VSUBS.n14 280
R66 VSUBS.n13 VSUBS.n15 280
R67 VSUBS.t17 VSUBS.t16 278.572
R68 VSUBS.t18 VSUBS.t17 278.572
R69 VSUBS.t19 VSUBS.t18 278.572
R70 VSUBS.t31 VSUBS.n10 269.44
R71 VSUBS.t29 VSUBS.t31 260
R72 VSUBS.t37 VSUBS.t29 260
R73 VSUBS.t39 VSUBS.t37 260
R74 VSUBS.n9 VSUBS.n7 234.5
R75 VSUBS.n9 VSUBS.n8 234.5
R76 VSUBS.n5 VSUBS.n8 116.9
R77 VSUBS.n4 VSUBS.n15 116.9
R78 VSUBS.n2 VSUBS.n11 115.501
R79 VSUBS.n2 VSUBS.n13 115.501
R80 VSUBS.t36 VSUBS.t43 114.611
R81 VSUBS.t6 VSUBS.t36 114.611
R82 VSUBS.t40 VSUBS.t35 114.611
R83 VSUBS.t34 VSUBS.t4 114.611
R84 VSUBS.t30 VSUBS.t34 114.611
R85 VSUBS.t38 VSUBS.t5 114.611
R86 VSUBS.n24 VSUBS.t38 114.611
R87 VSUBS.n5 VSUBS.n7 114.1
R88 VSUBS.n4 VSUBS.n14 114.1
R89 VSUBS.t4 VSUBS.n2 110.516
R90 VSUBS.t0 VSUBS.t40 107.243
R91 VSUBS.t43 VSUBS.n27 106.424
R92 VSUBS.t5 VSUBS.t7 99.8746
R93 VSUBS.t35 VSUBS.t10 86.7763
R94 VSUBS.n22 VSUBS.n5 83.5719
R95 VSUBS.t10 VSUBS.t6 27.8343
R96 VSUBS.t2 VSUBS.n23 24.095
R97 VSUBS.t2 VSUBS.n12 24.095
R98 VSUBS.n26 VSUBS.t25 24.095
R99 VSUBS.t25 VSUBS.n25 24.095
R100 VSUBS.t7 VSUBS.t30 14.736
R101 VSUBS.n23 VSUBS.n16 12.0375
R102 VSUBS.n12 VSUBS.n20 12.0375
R103 VSUBS.n26 VSUBS.n17 12.0375
R104 VSUBS.n25 VSUBS.n19 12.0375
R105 VSUBS.t2 VSUBS.n3 7.913
R106 VSUBS VSUBS.t25 7.913
R107 VSUBS.n21 VSUBS.t2 7.90615
R108 VSUBS.t25 VSUBS.n1 7.90615
R109 VSUBS.n2 VSUBS.n1 5.96675
R110 VSUBS.t25 VSUBS.n0 5.92793
R111 VSUBS VSUBS.n6 5.8405
R112 VSUBS.t11 VSUBS.t2 5.56736
R113 VSUBS.t21 VSUBS.t25 5.23894
R114 VSUBS.t2 VSUBS.t8 5.23894
R115 VSUBS.n9 VSUBS.n3 5.20844
R116 VSUBS.n21 VSUBS.n9 5.0555
R117 VSUBS.n4 VSUBS.t42 4.0937
R118 VSUBS.n2 VSUBS.t42 4.0937
R119 VSUBS.n4 VSUBS.t0 3.27506
R120 VSUBS.t23 VSUBS.n0 0.0284099
R121 VSUBS.n10 VSUBS.t21 2.18407
R122 VSUBS.n2 VSUBS.n6 2.02201
R123 VSUBS.n2 VSUBS.t11 1.7315
R124 VSUBS.n5 VSUBS.n21 1.49888
R125 VSUBS.n4 VSUBS.n1 1.49888
R126 VSUBS VSUBS.n4 1.358
R127 VSUBS.t8 VSUBS.n6 1.2605
R128 VSUBS.n5 VSUBS.n3 1.223
C0 a_27722_800# s2_fb 0.09349f
C1 w_13700_140# a_24600_2200# 0.01204f
C2 a_34330_2884# a_47720_2942# 0.03415f
C3 a_29624_2016# s2_fb 0.02361f
C4 s2_out s2_fb 0.15648f
C5 w_13700_140# a_18680_420# 0.55701f
C6 VDD a_34330_2884# 5.24658f
C7 VDD a_29280_400# 0.23759f
C8 VDD a_4186_430# 1.93212f
C9 VDD SIG 1.85284f
C10 a_6130_2884# a_6130_536# 0.61103f
C11 a_47440_420# VDD 0.05143f
C12 a_34330_2884# a_47160_2942# 0.03052f
C13 a_46880_420# VDD 0.05278f
C14 a_27722_1360# a_27722_800# 0.07722f
C15 a_27722_800# s2_out 0
C16 a_24600_1080# VDD 0.00151f
C17 a_46320_420# VDD 0.15478f
C18 a_24600_1640# VDD 0
C19 a_34330_536# VDD 4.80044f
C20 s1_out a_1612_368# 0.59937f
C21 a_29624_2016# s2_out 1.75218f
C22 a_27722_1360# s2_out 0.00149f
C23 a_27722_1360# a_27722_1920# 0.07722f
C24 a_32574_1878# VDD 2.37732f
C25 a_27722_1920# s2_out 0.00421f
C26 a_34330_2884# a_46600_2942# 0.02995f
C27 VDD a_1080_400# 0.23759f
C28 a_800_2922# a_240_2922# 0.06564f
C29 a_24600_1080# a_24600_520# 0.06564f
C30 a_6130_2884# a_18400_2942# 0.02995f
C31 a_34330_2884# w_41900_140# 11.3713f
C32 s1_out a_18960_2942# 0.0011f
C33 a_6130_2884# VDD 5.14542f
C34 a_32386_430# a_32386_1878# 0.02111f
C35 a_4374_1878# a_1612_368# 1.50907f
C36 VDD a_6130_536# 4.77556f
C37 a_34330_2884# a_46040_2942# 0.02977f
C38 a_47440_420# w_41900_140# 0.64626f
C39 s1_out a_19520_2942# 0.00104f
C40 a_46880_420# w_41900_140# 0.55701f
C41 a_32386_430# a_29812_368# 3.56144f
C42 a_46320_420# w_41900_140# 0.55812f
C43 a_29624_368# a_29812_368# 2.27244f
C44 a_28720_400# a_29280_400# 0.07233f
C45 a_1424_368# a_1424_2016# 0.00526f
C46 a_34330_536# w_41900_140# 0
C47 a_29000_2922# a_29280_400# 0.00522f
C48 a_1424_2016# a_1612_368# 0.71887f
C49 a_34330_2884# a_32386_1878# 0.0038f
C50 w_13700_140# a_18960_2942# 0.52055f
C51 a_32386_1878# a_29280_400# 0
C52 a_34330_2884# a_29812_368# 0.61782f
C53 a_32386_430# s2_fb 0.64114f
C54 a_29280_400# a_29812_368# 1.34038f
C55 a_34330_2884# REF 1.1085f
C56 w_13700_140# a_19520_2942# 0.61289f
C57 a_29624_368# s2_fb 0.12496f
C58 a_47720_2942# a_47160_2942# 0.08879f
C59 a_4186_1878# a_4374_1878# 2.7956f
C60 a_28440_2922# a_27722_2480# 0
C61 a_18120_420# VDD 0.15478f
C62 s1_out a_4186_430# 0.01705f
C63 a_19240_420# VDD 0.05143f
C64 VDD a_24600_520# 0.00465f
C65 a_32574_1878# a_32386_1878# 2.7956f
C66 s1_out SIG 0.1987f
C67 a_17840_2942# a_6130_2884# 0.02977f
C68 a_24600_2760# a_24600_2200# 0.06564f
C69 a_34330_2884# s2_fb 0.0094f
C70 a_34330_536# a_29812_368# 0.06012f
C71 a_29280_400# s2_fb 0.23f
C72 w_13700_140# a_24600_2760# 0.01106f
C73 s2_out OUTP 0.14427f
C74 a_34330_536# REF 0.01288f
C75 a_32574_1878# a_29812_368# 1.50907f
C76 a_24600_1080# s1_out 0.00112f
C77 a_1424_368# a_1612_368# 2.27244f
C78 a_32386_430# s2_out 0.00444f
C79 a_24600_1640# s1_out 0
C80 a_32574_1878# REF 1.04102f
C81 a_47720_2942# w_41900_140# 0.61289f
C82 a_4186_430# a_4374_1878# 0.02895f
C83 a_29624_368# a_29624_2016# 0.00526f
C84 a_29624_368# s2_out 0.00173f
C85 a_4374_1878# SIG 1.04102f
C86 VDD w_41900_140# 2.86872f
C87 a_47160_2942# a_46600_2942# 0.08879f
C88 a_29280_400# a_27722_800# 0
C89 a_34330_536# s2_fb 1.56054f
C90 s1_out a_6130_2884# 4.65509f
C91 a_47160_2942# w_41900_140# 0.52055f
C92 a_32574_1878# s2_fb 1.02019f
C93 a_34330_2884# s2_out 7.92232f
C94 a_24600_1640# a_24600_2200# 0.06564f
C95 a_29624_2016# a_29280_400# 4.5475f
C96 a_27722_1360# a_29280_400# 0
C97 a_29280_400# s2_out 0.09363f
C98 s1_out a_6130_536# 2.91956f
C99 a_27722_1920# a_29280_400# 0
C100 a_17840_2942# a_18400_2942# 0.08879f
C101 VDD a_28720_400# 0.0937f
C102 w_13700_140# a_24600_1080# 0.01316f
C103 a_4374_1878# a_1080_400# 0
C104 w_13700_140# a_24600_1640# 0.01204f
C105 a_1424_2016# a_800_2922# 0.07166f
C106 VDD a_32386_1878# 1.56751f
C107 a_47440_420# s2_out 0.01098f
C108 a_6130_2884# a_4374_1878# 0.16555f
C109 a_46600_2942# w_41900_140# 0.52055f
C110 a_46880_420# s2_out 0.01098f
C111 a_19520_2942# a_18960_2942# 0.08879f
C112 a_46320_420# s2_out 0.01098f
C113 a_4374_1878# a_6130_536# 0.1647f
C114 VDD a_29812_368# 7.07798f
C115 a_4186_1878# a_1612_368# 1.60167f
C116 w_13700_140# a_6130_2884# 11.3936f
C117 a_46600_2942# a_46040_2942# 0.08879f
C118 a_34330_536# s2_out 1.8967f
C119 VDD REF 1.84474f
C120 a_1424_2016# a_1080_400# 4.5475f
C121 a_32574_1878# s2_out 0.22932f
C122 a_27722_2480# s2_out 0.11052f
C123 a_27722_1920# a_27722_2480# 0.07722f
C124 w_13700_140# a_6130_536# 0
C125 s1_out a_18400_2942# 0.00132f
C126 a_46040_2942# w_41900_140# 0.6131f
C127 s1_out VDD 6.55825f
C128 a_1424_368# a_4186_430# 0.00137f
C129 a_4186_430# a_1612_368# 3.56144f
C130 VDD s2_fb 2.65043f
C131 s1_out a_18120_420# 0.00776f
C132 s1_out a_19240_420# 0.00776f
C133 s1_out a_24600_520# 0.09257f
C134 SIG a_1612_368# 0.26537f
C135 VDD a_4374_1878# 2.37732f
C136 a_520_400# a_1080_400# 0.07233f
C137 w_13700_140# a_18400_2942# 0.52055f
C138 w_13700_140# VDD 2.81506f
C139 a_32386_430# a_29624_368# 0.00137f
C140 VDD a_18680_420# 0.05278f
C141 a_28440_2922# a_29000_2922# 0.06564f
C142 VDD a_27722_800# 0.00303f
C143 a_1424_368# a_1080_400# 1.66376f
C144 VDD a_1424_2016# 0.56148f
C145 a_47720_2942# s2_out 0.01137f
C146 a_1612_368# a_1080_400# 1.34038f
C147 VDD a_29624_2016# 0.56148f
C148 a_27722_1360# VDD 0.00104f
C149 w_13700_140# a_18120_420# 0.55812f
C150 w_13700_140# a_19240_420# 0.64626f
C151 VDD s2_out 4.08119f
C152 w_13700_140# a_24600_520# 0.01279f
C153 a_18120_420# a_18680_420# 0.08879f
C154 a_19240_420# a_18680_420# 0.08879f
C155 a_6130_2884# a_1612_368# 0.61725f
C156 a_32386_430# a_29280_400# 0.00683f
C157 a_29624_368# a_29280_400# 1.66376f
C158 a_32386_1878# a_29812_368# 1.60167f
C159 a_6130_536# a_1612_368# 0.05752f
C160 a_4186_1878# a_4186_430# 0.02111f
C161 a_47160_2942# s2_out 0.01144f
C162 a_32386_1878# REF 0.02072f
C163 s1_out a_17840_2942# 0.003f
C164 a_1424_2016# a_240_2922# 0.0036f
C165 a_4186_1878# SIG 0.02072f
C166 a_6130_2884# a_18960_2942# 0.03052f
C167 VDD a_520_400# 0.0937f
C168 REF a_29812_368# 0.2631f
C169 a_28720_400# s2_fb 0.0148f
C170 a_32386_430# a_34330_536# 0.00418f
C171 a_46600_2942# s2_out 0.01165f
C172 a_19520_2942# a_6130_2884# 0.03415f
C173 a_32386_430# a_32574_1878# 0.02895f
C174 a_32386_1878# s2_fb 0.00607f
C175 a_1424_368# VDD 0.34118f
C176 w_41900_140# s2_out 16.1571f
C177 a_4186_1878# a_1080_400# 0
C178 VDD a_1612_368# 7.07798f
C179 w_13700_140# a_17840_2942# 0.6131f
C180 a_6130_2884# a_4186_1878# 0.0038f
C181 a_46040_2942# s2_out 0.01333f
C182 a_29812_368# s2_fb 1.33902f
C183 a_34330_536# a_34330_2884# 0.62008f
C184 REF s2_fb 0.21873f
C185 a_18400_2942# a_18960_2942# 0.08879f
C186 a_24600_2760# a_6130_2884# 0.00138f
C187 a_32574_1878# a_34330_2884# 0.16555f
C188 a_47440_420# a_46880_420# 0.08879f
C189 a_32574_1878# a_29280_400# 0
C190 a_28440_2922# a_29624_2016# 0.0036f
C191 a_28440_2922# s2_out 0.02744f
C192 a_29000_2922# a_29624_2016# 0.07166f
C193 a_29000_2922# s2_out 0.02361f
C194 s1_out a_4374_1878# 0.90854f
C195 a_4186_430# a_1080_400# 0.00683f
C196 a_46880_420# a_46320_420# 0.08879f
C197 a_32386_1878# s2_out 0.78964f
C198 a_24600_1080# a_24600_1640# 0.06564f
C199 a_800_2922# a_1080_400# 0.00522f
C200 w_13700_140# s1_out 14.0504f
C201 s1_out a_18680_420# 0.00776f
C202 a_6130_2884# SIG 1.12703f
C203 a_29624_2016# a_29812_368# 0.71887f
C204 VDD OUTP 0.22538f
C205 a_4186_430# a_6130_536# 0.00418f
C206 s2_out a_29812_368# 1.09385f
C207 a_34330_536# a_32574_1878# 0.1647f
C208 s2_out REF 0.63341f
C209 a_32386_430# VDD 1.93212f
C210 SIG a_6130_536# 0.01618f
C211 a_4186_1878# VDD 1.56751f
C212 a_29624_368# VDD 0.34118f
C213 OUTP VSUBS 3.73026f
C214 VDD VSUBS 0.18617p
C215 a_47720_2942# VSUBS 0.09593f
C216 a_47440_420# VSUBS 0.09564f
C217 a_47160_2942# VSUBS 0.09495f
C218 a_46880_420# VSUBS 0.09564f
C219 a_46600_2942# VSUBS 0.09495f
C220 a_46320_420# VSUBS 0.09564f
C221 a_46040_2942# VSUBS 0.09593f
C222 a_34330_536# VSUBS 1.506f
C223 a_32386_430# VSUBS 0.05612f
C224 a_32386_1878# VSUBS 1.3692f
C225 a_32574_1878# VSUBS 2.96035f
C226 a_29624_368# VSUBS 1.55522f
C227 a_29000_2922# VSUBS 0.82448f
C228 a_28720_400# VSUBS 0.81216f
C229 a_28440_2922# VSUBS 0.90167f
C230 a_29624_2016# VSUBS 5.19039f
C231 a_24600_520# VSUBS 0.49915f
C232 a_27722_800# VSUBS 0.51194f
C233 a_24600_1080# VSUBS 0.49874f
C234 a_27722_1360# VSUBS 0.5114f
C235 a_24600_1640# VSUBS 0.49878f
C236 a_27722_1920# VSUBS 0.51162f
C237 a_24600_2200# VSUBS 0.49934f
C238 a_27722_2480# VSUBS 0.5117f
C239 a_24600_2760# VSUBS 0.54135f
C240 a_19520_2942# VSUBS 0.09593f
C241 a_19240_420# VSUBS 0.09564f
C242 a_18960_2942# VSUBS 0.09495f
C243 a_18680_420# VSUBS 0.09564f
C244 a_18400_2942# VSUBS 0.09495f
C245 a_18120_420# VSUBS 0.09564f
C246 a_17840_2942# VSUBS 0.09593f
C247 a_6130_536# VSUBS 1.99268f
C248 a_4186_430# VSUBS 0.05612f
C249 a_6130_2884# VSUBS 0.0846f
C250 a_4186_1878# VSUBS 0.01223f
C251 a_4374_1878# VSUBS 2.11377f
C252 a_1424_368# VSUBS 1.55522f
C253 a_800_2922# VSUBS 0.82448f
C254 a_520_400# VSUBS 0.81216f
C255 a_240_2922# VSUBS 0.90259f
C256 a_1424_2016# VSUBS 5.19732f
C257 w_41900_140# VSUBS 0.14083p
C258 w_13700_140# VSUBS 0.12733p
C259 VSUBS.t25 VSUBS 5.63918f
C260 VSUBS.t2 VSUBS 1.65381f
C261 VDD.t8 VSUBS 2.40706f
C262 VDD.t18 VSUBS 2.40706f
C263 VDD.t11 VSUBS 0.58945f
C264 VDD.t19 VSUBS 0.58945f
C265 VDD.t10 VSUBS 4.78478f
C266 VDD.t21 VSUBS 3.42781f
C267 VDD.t24 VSUBS 7.23221f
C268 VDD.t23 VSUBS 10.007f
C269 VDD.n2 VSUBS 1.4922f
C270 VDD.n3 VSUBS 1.4922f
C271 VDD.t22 VSUBS 0.97106f
C272 VDD.t20 VSUBS 4.01564f
C273 VDD.t2 VSUBS 4.34073f
C274 VDD.t17 VSUBS 3.36855f
C275 VDD.t16 VSUBS 1.16104f
C276 VDD.t15 VSUBS 0.92883f
C277 VDD.t14 VSUBS 0.92883f
C278 VDD.t13 VSUBS 0.98305f
C279 VDD.t0 VSUBS 1.44814f
C280 VDD.t12 VSUBS 0.97106f
C281 VDD.t9 VSUBS 4.01564f
C282 VDD.t1 VSUBS 4.34073f
C283 VDD.t7 VSUBS 3.36855f
C284 VDD.t6 VSUBS 1.16104f
C285 VDD.t5 VSUBS 0.92883f
C286 VDD.t4 VSUBS 0.92883f
C287 VDD.t3 VSUBS 0.98305f
C288 VDD.t25 VSUBS 2.70908f
.ends
